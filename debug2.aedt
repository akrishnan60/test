# Ansys Electronics Desktop project, version 2023.1
materials:
  vacuum: permittivity=1
  iron: permeability=4000 conductivity=10300000
  PVC plastic: permittivity=2.7 dielectric_loss_tangent=0.007
  copper: permeability=0.999991 conductivity=58000000 core_loss_type=None mass_density=8933 stacking_type="Litz Wire" wire_type=Round strand_number=2 wire_diameter=2.588mm
  air: permittivity=1.0006 permeability=1.0000004
  ferrite: permittivity=12 permeability=1000 conductivity=0.01 core_loss_type="Power Ferrite" core_loss_cm=3.2 core_loss_x=1.46 core_loss_y=2.75 mass_density=4600 core_loss_equiv_cut_depth=0.001meter

design Maxwell3DDesign1 (Maxwell 3D, Transient, model units in)
options: ComputeTransientInductance
geometry:
  PolygonHelix1 = user_primitive(SegmentedHelix/PolygonHelix.dll, PolygonSegments=0, PolygonRadius=0.04in, StartHelixRadius=0.45in, RadiusChange=0in, Pitch=0.175in, Turns=2, SegmentsPerTurn=36, RightHanded=1)
  PolygonHelix2 = user_primitive(SegmentedHelix/PolygonHelix.dll, PolygonSegments=0, PolygonRadius=0.04in, StartHelixRadius=0.45in, RadiusChange=0in, Pitch=0.175in, Turns=2, SegmentsPerTurn=36, RightHanded=1)
  PolygonHelix2.move(0in, 0in, 0.085in)
  PolygonHelix1.move(-0.05in, 0in, 0in)
  [PolygonHelix1, PolygonHelix2].move(-0.025in, 0in, 0in)
  PolygonHelix2.move(-0.05in, 0in, 0in)
  PolygonHelix2.move(0in, 0in, 0.1in)
  PolygonHelix1.move(0in, 0in, 0.1in)
  [PolygonHelix2, PolygonHelix1].move(0in, 0in, 0.1in)
  [PolygonHelix1, PolygonHelix2].move(0in, 0in, 0.2in)
  PolygonHelix1.move(0in, 0in, -0.05in)
  PolygonHelix2.move(0in, 0in, -0.05in)
  [PolygonHelix1, PolygonHelix2].move(0in, 0in, -0.05in)
  [PolygonHelix2, PolygonHelix1].move(0in, -0.005in, 0in)
  [PolygonHelix2, PolygonHelix1].move(0.005in, 0in, 0in)
  Box1 [copper] = box(corner=(0.48317644in, 0.98741705in, 0in), size=(-0.070928485in, -0.85844207in, 0.030259817in))
  Box1.move(-0.069434246in, -0.13397497in, 0.28488404in)
  Box1.scale(0.5, 1, 1)
  Box1.move(0.18930549in, 0in, 0.0022257269in)
  Box1.move(0in, -0.85681703in, -0.00084308023in)
  Box1.rotate(axis=Z, angle=-20deg)
  Box1.move(0in, 0.12997504in, 0.0015011874in)
  Box1.move(0.030678578in, -0.0071626229in, 0in)
  Box1.move(0.0031746448in, 0.0098728607in, 0in)
  Box2 = box(corner=(0.48317644in, 0.98741705in, 0in), size=(-0.070928485in, -0.85844207in, 0.030259817in))
  Box2.move(-0.069434246in, -0.13397497in, 0.28488404in)
  Box2.scale(0.5, 1, 1)
  Box2.move(0.18930549in, 0in, 0.0022257269in)
  Box2.move(0in, -0.85681703in, -0.00084308023in)
  Box2.rotate(axis=Z, angle=-20deg)
  Box2.move(0in, 0.12997504in, 0.0015011874in)
  Box2.move(0.030678578in, -0.0071626229in, 0in)
  Box2.move(0.0031746448in, 0.0098728607in, 0in)
  Box2.move(0in, 0in, 0.07in)
  Box3 = box(corner=(0.48317644in, 0.98741705in, 0in), size=(-0.070928485in, -0.85844207in, 0.030259817in))
  Box3.move(-0.069434246in, -0.13397497in, 0.28488404in)
  Box3.scale(0.5, 1, 1)
  Box3.move(0.18930549in, 0in, 0.0022257269in)
  Box3.move(0in, -0.85681703in, -0.00084308023in)
  Box3.rotate(axis=Z, angle=-20deg)
  Box3.move(0in, 0.12997504in, 0.0015011874in)
  Box3.move(0.030678578in, -0.0071626229in, 0in)
  Box3.move(0.0031746448in, 0.0098728607in, 0in)
  Box4 = box(corner=(0.48317644in, 0.98741705in, 0in), size=(-0.070928485in, -0.85844207in, 0.030259817in))
  Box4.move(-0.069434246in, -0.13397497in, 0.28488404in)
  Box4.scale(0.5, 1, 1)
  Box4.move(0.18930549in, 0in, 0.0022257269in)
  Box4.move(0in, -0.85681703in, -0.00084308023in)
  Box4.rotate(axis=Z, angle=-20deg)
  Box4.move(0in, 0.12997504in, 0.0015011874in)
  Box4.move(0.030678578in, -0.0071626229in, 0in)
  Box4.move(0.0031746448in, 0.0098728607in, 0in)
  Box4.move(0in, 0in, 0.07in)
  [Box3, Box4].move(0.80315526in, 0.85587339in, 0.56454787in)
  [Box3, Box4].rotate(axis=Z, angle=40deg)
  [Box3, Box4].move(0.66696953in, -0.23481333in, 0in)
  [Box4, Box3].move(-0.68114933in, -1.312997in, -0.31379009in)
  [Box4, Box3].move(-0.27912087in, 0.82882675in, 0in)
  [Box4, Box3].move(0.039140878in, 0in, 0.039475224in)
  [Box4, Box3].move(0.016662744in, 0.0060647427in, 0in)
  [Box4, Box3].move(-0.053246505in, 0.079056771in, 0in)
  [Box4, Box3].move(0.005in, 0in, 0.005in)
  [Box4, Box3].move(0.01in, 0in, 0.005in)
  Box5 = box(corner=(0.11137865in, -0.81265819in, 0.31802769in), size=(-0.033325487in, 0.012129485in, 0.07in))
  Box6 = box(corner=(0.11137865in, -0.81265819in, 0.31802769in), size=(-0.033325487in, 0.012129485in, 0.07in))
  Box6.move(0in, 1.4310516in, -0.11703749in)
  Box6.move(0in, 0.16286029in, 0.39852535in)
  Box5.scale(1, 2, 1)
  Box5.scale(1, 2, 1)
  Box5.move(0in, 4in, 0in)
  Box5.move(0in, -1.5in, 0in)
  Box5.move(0in, -0.05in, 0in)
  Box5.move(0in, -0.025in, 0in)
  Box6.scale(1, 2, 1)
  Box6.move(0in, -1.3in, 0in)
  Box6.move(0in, 0.2in, 0in)
  Box6.move(0in, 0.3in, 0in)
  Box6.move(0in, 0.01in, 0in)
  Box6.scale(1, 2, 1)
  Box6.move(0in, -0.6in, 0in)
  Box6.move(0in, -0.2in, 0in)
  Box6.move(0in, 0.025in, 0in)
  Region [air] = region(percentage_offset=0 on all sides)
  [Box6, Box4, Box3].move(0in, 0in, 0.04in)
  [Box6, Box4, Box3].move(0in, 0in, 0.015in)
  Box5.move(0in, 0in, -0.03in)
  Box5.move(0in, 0in, 0.01in)
  Box1.unite(Box2..Box6, PolygonHelix1, PolygonHelix2)
boundaries and excitations:
  CoilTerminal1: Coil Terminal Faces=Box1.face(at (0.0947159, -0.825633, 0.333028)) Conductor_number=1 Winding=Winding1 Point_out_of_terminal=false
  CoilTerminal2: Coil Terminal Faces=Box1.face(at (0.0947159, 0.818533, 0.689516)) Conductor_number=1 Winding=Winding1 Point_out_of_terminal=true
  Winding1: Winding Group Type=Current IsSolid=false Current=75*sin(2*PI*200*1000*Time) ParallelBranchesNum=1
mesh:
  Length1: LengthBased Objects=Region MaxLength=0.33383311in
  initial mesh: GlobalCurvilinear{Apply}
setups:
  Setup1: Transient NonlinearSolverResidual=0.005 ScalarPotential="Second Order" StopTime=5s TimeStep=1s
reports:
  Loss Plot 1: CoreLoss, EddyCurrentLoss, ExcessLoss, HysteresisLoss, PerWindingStrandedLoss(Winding1), SolidLoss, StrandedLoss, StrandedLossAC, StrandedLossR vs Time on Setup1 : Transient
  Winding Plot 1: L(Winding1,Winding1), FluxLinkage(Winding1), InducedVoltage(Winding1), InputCurrent(Winding1) vs Time on Setup1 : Transient
